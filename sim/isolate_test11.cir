* Test the exact attenuator+coupling chain from the full circuit, fed by a simple ideal source,
* to isolate whether THAT specific network (not the envelope/Bsig apparatus) is the problem.
.include lm13700.sub
Vccs VCCS 0 4.5
Vsss VSSS 0 -4.5
Vsig U1AOUT 0 SINE(0 0.8 100)
Rattn_a U1AOUT ATTMID 100k
Rattn_b ATTMID 0 1.6k
C2 ATTMID OTAIN 1u
R3 OTAIN 0 10k
RD VCCS DBIAS1 7.5k
RABC VCCS IABC1 13k
R4 OUT1 0 47k
XOTA1 DBIAS1 OTAIN 0 IABC1 OUT1 VCCS VSSS VSSS BUF1 HALF13700
RBUFBLEED BUF1 VSSS 1G
.tran 0 0.03 0 20u
.end
