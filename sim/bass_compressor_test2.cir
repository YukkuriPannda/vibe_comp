* Bass Compressor - core audio path verification (Phase 2 SPICE check, v2)
* Based on docs/circuit_reference.md (post R_ABC=820k->13k / attenuator / R_prebias fixes)
*
* IMPORTANT SIMULATION NOTE: the deanm1278 LM13700 SPICE model gives ZERO output when its
* VSS pin is tied to exactly 0V (confirmed via isolate_test1-8.cir - a model limitation,
* not a real-chip limitation; the real LM13700 supports true single-supply V-=0V operation
* per its datasheet). Workaround: simulate in a reference frame shifted by -4.5V so nothing
* sits at exactly 0V for the OTA's VSS pin. Mapping: real GND(0V) -> sim node VSSS(-4.5V),
* real V+(9V) -> sim node VCCS(+4.5V), real Vref(4.5V) -> sim ground "0". This is a pure
* relabeling of the reference point and changes nothing electrically vs the real circuit.

.include lm13700.sub

.subckt OPAMP INP INN OUT
Ri INP INN 10MEG
E1 N4 0 INP INN 200k
Rp N4 0 1MEG
Cp N4 0 10.6n
Ro N4 OUT 50
.ends OPAMP

.model D1N4148 D(IS=2.52n N=1.752 RS=0.568 CJO=4p TT=20n)
.model QGEN NPN(IS=1e-14 BF=200 VAF=100)

* --- power / bias (shifted frame: sim ground == real Vref) ---
Vccs VCCS 0 4.5
Vsss VSSS 0 -4.5

* --- test input: quiet(0.05Vpk) -> sudden loud(0.8Vpk) at 50ms -> back to quiet at 250ms ---
Venv ENV VSSS PWL(0 0.05 0.05 0.05 0.052 0.8 0.25 0.8 0.252 0.05 1.0 0.05)
Bsig INSRC VSSS V=V(ENV,VSSS)*sin(2*3.14159265*100*time)

* --- input buffer (U1A, unity gain follower) ---
Cin INSRC N1 0.1u
Rinbias N1 0 1MEG
XU1A N1 U1AOUT U1AOUT OPAMP

* --- OTA gain stage (LM13700 OTA#1) ---
* NOTE (3rd SPICE iteration): attenuating AFTER the coupling cap with a low-value R3-to-V-
* fought the OTA input's natural DC bias point (pulled it to within ~80mV of V-, starving
* the input transistor). Fixed by attenuating BEFORE the coupling cap instead (in the
* Vref-centered domain, where a stiff divider doesn't disturb anything), then coupling the
* already-attenuated signal in through a weak/high-value bias resistor as before.
* NOTE (4th iteration): OTAIN's DC bias via R3-to-VSSS(V-) sat only ~0.17V above V-,
* nowhere near the mid-supply/Vref region the differential pair apparently needs to
* operate (confirmed: an isolated test biasing the input near mid-supply worked fine,
* one biased near V- gave zero output). Re-biasing R3 (and INN, for a matched common-mode
* point) to Vref/sim-ground "0" instead of VSSS.
Rattn_a U1AOUT ATTMID 100k
Rattn_b ATTMID 0 1.6k
C2 ATTMID OTAIN 1u
R3 OTAIN 0 100k
RD VCCS DBIAS1 7.5k
RABC VCCS IABC1 75k
R4 OUT1 0 47k
XOTA1 DBIAS1 OTAIN 0 IABC1 OUT1 VCCS VSSS VSSS BUF1 HALF13700
RBUFBLEED BUF1 VSSS 1G

QCTRL IABC1 QBASE VSSS QGEN

* --- envelope detector + prebias ---
Cenv OUT1 NODEA 0.1u
Renvbias NODEA VSSS 1MEG
D1 NODEA D1K D1N4148
Rattack D1K NODEE 2.2k
Chold NODEE VSSS 1u
Rrelease NODEE VSSS 220k
Rprebias VCCS NODEE 3.3MEG

.param SUSTAIN_FRAC=0.7
Rpot_top NODEE WIPER {(1-SUSTAIN_FRAC)*10k+1}
Rpot_bot WIPER VSSS {SUSTAIN_FRAC*10k+1}
Rbase WIPER QBASE 2.2k

* --- makeup gain stage (U1B) ---
C3 OUT1 N5 1u
R5 N5 0 100k
XU1B N5 U1BINN U1BOUT OPAMP
R6 U1BINN VSSS 10k
R7 U1BINN U1BOUT 47k

* --- output stage (Level pot VR2 fixed near max for this test) ---
C4 U1BOUT N6 1u
.param LEVEL_FRAC=0.9
Rvr2_top N6 LVLWIPER {(1-LEVEL_FRAC)*10k+1}
Rvr2_bot LVLWIPER VSSS {LEVEL_FRAC*10k+1}
C5 LVLWIPER OUTFINAL 1u
Rload OUTFINAL VSSS 1MEG

.tran 0 0.8 0 50u

.backanno
.end
