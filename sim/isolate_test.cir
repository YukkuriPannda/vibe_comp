* Isolate test: drive OTAIN directly with a small AC voltage source (no coupling network)
* to check whether the single-supply (VCC=9,VSS=0) OTA+RABC+R4 biasing itself works.
.include lm13700.sub
.model D1N4148 D(IS=2.52n N=1.752 RS=0.568 CJO=4p TT=20n)
.model QGEN NPN(IS=1e-14 BF=200 VAF=100)

Vcc VCC 0 9
R1 VCC VREF 100k
R2 VREF 0 100k

Vsig OTAIN 0 SINE(0 15m 100)
RD VCC DBIAS1 7.5k
RABC VCC IABC1 13k
R4 OUT1 VREF 47k
XOTA1 DBIAS1 OTAIN 0 IABC1 OUT1 VCC 0 0 BUF1 HALF13700
RBUFBLEED BUF1 0 1G

.tran 0 0.05 0 20u
.end
