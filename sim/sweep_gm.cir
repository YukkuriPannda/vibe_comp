* Sweep IABC to find actual achievable gm/gain with this specific SPICE model,
* using the corrected mid-supply input biasing scheme.
.include lm13700.sub
Vccs VCCS 0 4.5
Vsss VSSS 0 -4.5
Vsig OTAIN 0 SINE(0 15m 100)
.param IABCVAL=100u
Iabc 0 IABC1 {IABCVAL}
.step param IABCVAL list 20u 100u 500u 1m 3m 5m
R4 OUT1 0 47k
XOTA1 NC1 OTAIN 0 IABC1 OUT1 VCCS VSSS VSSS BUF1 HALF13700
RBUFBLEED BUF1 VSSS 1G
.tran 0 0.03 0 20u
.end
