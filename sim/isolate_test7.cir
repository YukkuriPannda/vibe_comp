* Isolate test 7: single supply VCC=9/VSS=0, but do NOT tie INN directly to the same
* node as VSS - give it a tiny explicit bias instead, to see if that's the real issue.
.include lm13700.sub
Vcc VCC 0 9
Vsig OTAIN 0 SINE(0 15m 100)
Iabc 0 IABC1 1m
Vinn INN 0 0.05
R4a OUT1 VCC 47k
R4b OUT1 0 47k
XOTA1 NC1 OTAIN INN IABC1 OUT1 VCC 0 0 BUF1 HALF13700
RBUFBLEED BUF1 0 1G
.tran 0 0.05 0 20u
.end
